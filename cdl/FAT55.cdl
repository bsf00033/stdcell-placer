************************************************************************
* Cell:    FAT55
* 55 MOS speed-eval netlist (28 N + 27 P). Not a real function.
* N: four series stacks (7+7+6+5) plus 3 singles.
* P: 27 parallel pullups on Z.
************************************************************************
.SUBCKT FAT55 A B C D E F G H Z VDD VSS
.PININFO A:I B:I C:I D:I E:I F:I G:I H:I Z:O VDD:P VSS:G
Mp1 Z A VDD VDD PMOS W=0.40U L=0.05U
Mp2 Z B VDD VDD PMOS W=0.40U L=0.05U
Mp3 Z C VDD VDD PMOS W=0.40U L=0.05U
Mp4 Z D VDD VDD PMOS W=0.40U L=0.05U
Mp5 Z E VDD VDD PMOS W=0.40U L=0.05U
Mp6 Z F VDD VDD PMOS W=0.40U L=0.05U
Mp7 Z G VDD VDD PMOS W=0.40U L=0.05U
Mp8 Z H VDD VDD PMOS W=0.40U L=0.05U
Mp9 Z A VDD VDD PMOS W=0.40U L=0.05U
Mp10 Z B VDD VDD PMOS W=0.40U L=0.05U
Mp11 Z C VDD VDD PMOS W=0.40U L=0.05U
Mp12 Z D VDD VDD PMOS W=0.40U L=0.05U
Mp13 Z E VDD VDD PMOS W=0.40U L=0.05U
Mp14 Z F VDD VDD PMOS W=0.40U L=0.05U
Mp15 Z G VDD VDD PMOS W=0.40U L=0.05U
Mp16 Z H VDD VDD PMOS W=0.40U L=0.05U
Mp17 Z A VDD VDD PMOS W=0.40U L=0.05U
Mp18 Z B VDD VDD PMOS W=0.40U L=0.05U
Mp19 Z C VDD VDD PMOS W=0.40U L=0.05U
Mp20 Z D VDD VDD PMOS W=0.40U L=0.05U
Mp21 Z E VDD VDD PMOS W=0.40U L=0.05U
Mp22 Z F VDD VDD PMOS W=0.40U L=0.05U
Mp23 Z G VDD VDD PMOS W=0.40U L=0.05U
Mp24 Z H VDD VDD PMOS W=0.40U L=0.05U
Mp25 Z A VDD VDD PMOS W=0.40U L=0.05U
Mp26 Z B VDD VDD PMOS W=0.40U L=0.05U
Mp27 Z C VDD VDD PMOS W=0.40U L=0.05U
MnA1 Z A N1 VSS NMOS W=0.20U L=0.05U
MnA2 N1 B N2 VSS NMOS W=0.20U L=0.05U
MnA3 N2 C N3 VSS NMOS W=0.20U L=0.05U
MnA4 N3 D N4 VSS NMOS W=0.20U L=0.05U
MnA5 N4 E N5 VSS NMOS W=0.20U L=0.05U
MnA6 N5 F N6 VSS NMOS W=0.20U L=0.05U
MnA7 N6 G VSS VSS NMOS W=0.20U L=0.05U
MnB1 Z B N11 VSS NMOS W=0.20U L=0.05U
MnB2 N11 A N12 VSS NMOS W=0.20U L=0.05U
MnB3 N12 C N13 VSS NMOS W=0.20U L=0.05U
MnB4 N13 D N14 VSS NMOS W=0.20U L=0.05U
MnB5 N14 E N15 VSS NMOS W=0.20U L=0.05U
MnB6 N15 F N16 VSS NMOS W=0.20U L=0.05U
MnB7 N16 H VSS VSS NMOS W=0.20U L=0.05U
MnC1 Z C N21 VSS NMOS W=0.20U L=0.05U
MnC2 N21 D N22 VSS NMOS W=0.20U L=0.05U
MnC3 N22 E N23 VSS NMOS W=0.20U L=0.05U
MnC4 N23 F N24 VSS NMOS W=0.20U L=0.05U
MnC5 N24 G N25 VSS NMOS W=0.20U L=0.05U
MnC6 N25 H VSS VSS NMOS W=0.20U L=0.05U
MnD1 Z D N31 VSS NMOS W=0.20U L=0.05U
MnD2 N31 E N32 VSS NMOS W=0.20U L=0.05U
MnD3 N32 F N33 VSS NMOS W=0.20U L=0.05U
MnD4 N33 G N34 VSS NMOS W=0.20U L=0.05U
MnD5 N34 H VSS VSS NMOS W=0.20U L=0.05U
MnS1 Z E VSS VSS NMOS W=0.20U L=0.05U
MnS2 Z F VSS VSS NMOS W=0.20U L=0.05U
MnS3 Z H VSS VSS NMOS W=0.20U L=0.05U
.ENDS FAT55
